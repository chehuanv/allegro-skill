;; ============================================================
;; File: route_linetoshape.il
;; Purpose: Line to shape
;; Encoding: ASCII
;; ============================================================

;axlSetFunckey("c2s" "c2sXXX")
procedure( ASTB_Route_LineToShape()
let( ()
 axlSetFindFilter(?enabled list("noall" "clines" "lines" )
                  ?onButtons list("noall" "clines" "lines"))
 LCBpopup = axlUIPopupDefine( nil (list
	(list "Done" 'LCB_Done)
    (list "Undo" 'LCB_unDo)
    (list "Cancel" 'LCB_Cancel)
     ))
 axlUIPopupSet(LCBpopup)

 LCB_mark = axlDBTransactionStart()
 notdone = t
 while(notdone
  lclines = axlGetSelSet(axlSelect(?prompt "Select Clines to convert to a shape."))
  if(lclines then
    foreach(clinedbid lclines
      ;layer = "etch/bottom"
      layer = car(axlGetSelSet())->layer
       polydbid = axlPolyFromDB(clinedbid ?endCapType "ROUND")
       if(polydbid then
        ;axlDeleteObject(clinedbid)
        if(! axlDBCreateShape(car(polydbid) t layer)  then
          axlUIWPrint(nil "** Error. Failed to create Shape from Cline. **")
        ); endif
	if(cadr(polydbid) then
            axlDBCreateShape(cadr(polydbid) t layer)  )
       else
        axlUIWPrint(nil "** Error. Failed to create Polydbid from Cline. **")
       ); endif
    ); end foreach cline
  ); endif
 ); end while
 axlDBTransactionCommit(LCB_mark)

)); let and procedure

procedure(LCB_unDo()
let( ()
  if(! axlDBTransactionOops(LCB_mark) then
    axlUIWPrint(nil "-- Nothing Left To Undo. --")
  else
    axlUIWPrint(nil "-- Replacing Clines. --")
  ); endif
  axlClearSelSet()
)); end let procedure

procedure(LCB_Cancel()
let( ()
  axlUIWPrint(nil "** Cancelled Program. **")
  ;axlDBTransactionRollback(LCB_mark)
  notdone = nil
  axlClearSelSet()
  axlCancelEnterFun()

)); end let procedure

procedure(LCB_Done()
 let( ()
  axlUIWPrint(nil "-- Done. --")
  notdone = nil
  axlDBTransactionCommit(LCB_mark)
  axlClearSelSet()
  axlCancelEnterFun()
 )); end let procedure

ASTB_RegisterCommand("ASTB_Route_LineToShape" "ASTB_Route_LineToShape" ?cmdType 'interactive)

printf("[ASTB] route_linetoshape.il loaded.\n")
